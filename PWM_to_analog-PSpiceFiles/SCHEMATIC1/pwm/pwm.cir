** Profile: "SCHEMATIC1-pwm"  [ H:\00_Fall_2019\JEDL\Project1\PSpice\PWM_to_analog-PSpiceFiles\SCHEMATIC1\pwm.sim ]

** Creating circuit file "pwm.cir"
** WARNING: THIS AUTOMATICALLY GENERATED FILE MAY BE OVERWRITTEN BY SUBSEQUENT SIMULATIONS

*Libraries:
* Profile Libraries :
* Local Libraries :
* From [PSPICE NETLIST] section of C:\Users\o167m805\cdssetup\OrCAD_PSpice\17.2.0\PSpice.ini file:
.lib "nom.lib"

*Analysis directives:
.TRAN  0 1 0 0.01
.OPTIONS ADVCONV
.PROBE64 V(alias(*)) I(alias(*)) W(alias(*)) D(alias(*)) NOISE(alias(*))
.INC "..\SCHEMATIC1.net"

.END
